RC low-pass demonstration
V1 in 0 AC 1 SIN(0 1 1k)
R1 in out 1k
C1 out 0 1u
D1 out 0 DMOD
.model DMOD D(IS=1e-14 N=1)
.include "external-model.lib"
.tran 1u 10m
V2 sense 0 DC 5
+ AC 1
.control
run
print v(out)
.endc
.end
